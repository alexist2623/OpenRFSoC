* SPDX-License-Identifier: MIT
* One physically sized steering transistor per branch (minimum W=0.42um).
* No fractional device multiplicity is used for the steering switches.
.subckt dac_cs_cell_shared outp outn gp gn vbias vcas vss params: WGT=1 SWDIV=128
.param WSW={max(0.42,0.42*WGT/SWDIV)}
Xtail tail vbias vss vss sky130_fd_pr__nfet_01v8 w=1 l=1 nf=1 mult={WGT} m={WGT} ad=0.29 as=0.29 pd=2.58 ps=2.58
Xcas common vcas tail vss sky130_fd_pr__nfet_01v8 w=1 l=0.3 nf=1 mult={WGT} m={WGT} ad=0.29 as=0.29 pd=2.58 ps=2.58
Xsp outp gp common vss sky130_fd_pr__nfet_01v8 w={WSW} l=0.15 nf=1 ad={0.29*WSW} as={0.29*WSW} pd={2*(WSW+0.29)} ps={2*(WSW+0.29)}
Xsn outn gn common vss sky130_fd_pr__nfet_01v8 w={WSW} l=0.15 nf=1 ad={0.29*WSW} as={0.29*WSW} pd={2*(WSW+0.29)} ps={2*(WSW+0.29)}
.ends dac_cs_cell_shared
