* SPDX-License-Identifier: MIT
* Candidate: extra output cascodes isolate the steering switches from the loads.
.subckt dac_cs_cell_output_cascode outp outn gp gn vbias vcas vdd vss params: WGT=1
Xtail tail vbias vss vss sky130_fd_pr__nfet_01v8 w=1 l=1 nf=1 mult={WGT} m={WGT} ad=0.29 as=0.29 pd=2.58 ps=2.58
Xcas common vcas tail vss sky130_fd_pr__nfet_01v8 w=1 l=0.3 nf=1 mult={WGT} m={WGT} ad=0.29 as=0.29 pd=2.58 ps=2.58
Xsp drainp gp common vss sky130_fd_pr__nfet_01v8 w=0.42 l=0.15 nf=1 mult={WGT} m={WGT} ad=0.1218 as=0.1218 pd=1.42 ps=1.42
Xsn drainn gn common vss sky130_fd_pr__nfet_01v8 w=0.42 l=0.15 nf=1 mult={WGT} m={WGT} ad=0.1218 as=0.1218 pd=1.42 ps=1.42
Xop outp vdd drainp vss sky130_fd_pr__nfet_01v8 w=0.42 l=0.15 nf=1 mult={WGT} m={WGT} ad=0.1218 as=0.1218 pd=1.42 ps=1.42
Xon outn vdd drainn vss sky130_fd_pr__nfet_01v8 w=0.42 l=0.15 nf=1 mult={WGT} m={WGT} ad=0.1218 as=0.1218 pd=1.42 ps=1.42
.ends dac_cs_cell_output_cascode
